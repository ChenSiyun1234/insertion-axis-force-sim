Independent resistive force divider: slow; all components assumed
Vexc supply 0 PULSE(0 3.3 1m 1n 1n 10m 20m)
Rforce supply divider 2454.8889833129756
Rdown divider 0 6800
Rfilter divider adc 4700
Cfilter adc 0 2.2e-07
.options reltol=1e-7 abstol=1e-12
.tran 1u 5m 0 1u
.end
